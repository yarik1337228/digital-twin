# Ansys Electronics Desktop project, version 2025.2
materials:
  vacuum: permittivity=1

design theta (HFSS, HFSS Terminal Network, model units mm)
geometry:
  wheels, wheels_1, wheels_2, wheels_3 [non-model] = imported_body(C:\Users\MSI\Downloads\car_model.step)
  body = imported_body(C:\Users\MSI\Downloads\car_model.step)
  RadiatingSurface [vacuum] = region(absolute_offset=90.991811mm on all sides)
  group body1 = wheels, wheels_1, wheels_2, wheels_3, body
boundaries and excitations:
  PerfE1: Perfect E Objects=body
  Open1: Radiation Objects=RadiatingSurface
  IncPWave1: Plane Incident Wave PhiStart=0deg PhiStop=360deg PhiPoints=181 ThetaStart=90deg ThetaStop=90deg ThetaPoints=1 EoPhi=0 EoTheta=1 OriginX=0mm OriginY=0mm OriginZ=0mm IsPropagating
mesh:
  Length1: LengthBased disabled Objects=body MaxLength=953.54719mm
  initial mesh: GlobalSurfApproximation{CurvedSurfaceApproxChoice=UseSlider SliderMeshSettings=1} GlobalModelRes{DefeatureLength=950mm}
setups:
  Setup1: HfssDriven Frequency=1099MHz MaxDeltaE=0.1 MaximumPasses=6 MinimumPasses=1 MinimumConvergedPasses=1 PercentRefinement=30 BasisOrder=1 DrivenSolverType="Direct Solver"
source amplitudes:
  IncPWave1:1: 1 0deg
radiation setups:
  3D: Infinite Sphere Theta=0deg..180deg step 2deg Phi=-180deg..180deg step 2deg
  Elevation: Infinite Sphere Theta=-180deg..180deg step 1deg Phi=0deg..90deg step 90deg
  Azimuth: Infinite Sphere Theta=90deg..90deg step 0deg Phi=-180deg..180deg step 1deg
field plots:
  Mag_E1: E Field over body.face(all 795) on Setup1 : LastAdaptive at Freq=1.099GHz IWavePhi=0deg IWaveTheta=90deg Phase=0deg
reports:
  Monostatic RCS Plot1: dB(MonostaticRCSTotal) vs IWavePhi, IWaveTheta on Setup1 : LastAdaptive [Freq=1.099GHz]

design phi (HFSS, HFSS Terminal Network, model units mm)
geometry:
  wheels, wheels_1, wheels_2, wheels_3 [non-model] = imported_body(C:\Users\MSI\Downloads\car_model.step)
  body = imported_body(C:\Users\MSI\Downloads\car_model.step)
  RadiatingSurface [vacuum] = region(absolute_offset=90.991811mm on all sides)
  group body1 = wheels, wheels_1, wheels_2, wheels_3, body
boundaries and excitations:
  PerfE1: Perfect E Objects=body
  Open1: Radiation Objects=RadiatingSurface
  IncPWave1: Plane Incident Wave PhiStart=180deg PhiStop=180deg PhiPoints=1 ThetaStart=-90deg ThetaStop=90deg ThetaPoints=91 EoPhi=1 EoTheta=0 OriginX=0mm OriginY=0mm OriginZ=0mm IsPropagating
mesh:
  Length1: LengthBased disabled Objects=body MaxLength=953.54719mm
  initial mesh: GlobalSurfApproximation{CurvedSurfaceApproxChoice=UseSlider SliderMeshSettings=1} GlobalModelRes{DefeatureLength=300mm}
setups:
  Setup1: HfssDriven Frequency=1099MHz MaxDeltaE=0.1 MaximumPasses=6 MinimumPasses=1 MinimumConvergedPasses=1 PercentRefinement=30 BasisOrder=1 DrivenSolverType="Direct Solver"
source amplitudes:
  IncPWave1:1: 1 0deg
radiation setups:
  3D: Infinite Sphere Theta=0deg..180deg step 2deg Phi=-180deg..180deg step 2deg
  Elevation: Infinite Sphere Theta=-180deg..180deg step 1deg Phi=0deg..90deg step 90deg
  Azimuth: Infinite Sphere Theta=90deg..90deg step 0deg Phi=-180deg..180deg step 1deg
field plots:
  Mag_E1: E Field over body.face(all 795) on Setup1 : LastAdaptive at Freq=1.099GHz IWavePhi=0deg IWaveTheta=90deg Phase=0deg
reports:
  Monostatic RCS Plot1: dB(MonostaticRCSTotal) vs IWavePhi, IWaveTheta on Setup1 : LastAdaptive [Freq=1.099GHz]
